* SKY130 2-Stage Pelliconi Cross-Coupled Charge Pump
* Eliminates Vth drops via cross-coupled NMOS/PMOS pairs
* All devices 5V-tolerant (g5v0d10v5)

.lib "sky130_models/sky130.lib.spice" tt

* Clock parameter
.param thalf_val = {Thalf}
.param tperiod_val = 2*thalf_val

* Supply
Vdd vdd 0 1.8
Vss vss 0 0

* Two-phase non-overlapping clocks
Vclk1 clk1 0 PULSE(0 1.8 0 0.1n 0.1n 'thalf_val*1e-9' 'tperiod_val*1e-9')
Vclk2 clk2 0 PULSE(0 1.8 'thalf_val*1e-9' 0.1n 0.1n 'thalf_val*1e-9' 'tperiod_val*1e-9')

* === Stage 1: Pelliconi cell (Vdd -> ~2*Vdd) ===
* NMOS cross-coupled pair (input charging)
* When k1 is boosted high, MN1 turns on charging j1 from Vdd
* When j1 is boosted high, MN2 turns on charging k1 from Vdd
XMN1 j1 k1 vdd 0 sky130_fd_pr__nfet_g5v0d10v5 W={Wn}u L={Ln}u nf=1
XMN2 k1 j1 vdd 0 sky130_fd_pr__nfet_g5v0d10v5 W={Wn}u L={Ln}u nf=1

* PMOS cross-coupled pair (output transfer)
* When k1 is low, MP1 passes boosted j1 to mid
* When j1 is low, MP2 passes boosted k1 to mid
XMP1 mid k1 j1 mid sky130_fd_pr__pfet_g5v0d10v5 W={Wp}u L={Lp}u nf=1
XMP2 mid j1 k1 mid sky130_fd_pr__pfet_g5v0d10v5 W={Wp}u L={Lp}u nf=1

* Stage 1 flying capacitors
C1a j1 clk1 {Cfly}p
C1b k1 clk2 {Cfly}p

* Interstage decoupling capacitor
Cmid mid 0 {Cmid}p

* === Stage 2: Pelliconi cell (~2*Vdd -> ~3*Vdd) ===
* NMOS cross-coupled pair
XMN3 j2 k2 mid 0 sky130_fd_pr__nfet_g5v0d10v5 W={Wn}u L={Ln}u nf=1
XMN4 k2 j2 mid 0 sky130_fd_pr__nfet_g5v0d10v5 W={Wn}u L={Ln}u nf=1

* PMOS cross-coupled pair
XMP3 vout k2 j2 vout sky130_fd_pr__pfet_g5v0d10v5 W={Wp}u L={Lp}u nf=1
XMP4 vout j2 k2 vout sky130_fd_pr__pfet_g5v0d10v5 W={Wp}u L={Lp}u nf=1

* Stage 2 flying capacitors
C2a j2 clk1 {Cfly}p
C2b k2 clk2 {Cfly}p

* === Output capacitor ===
Cout vout 0 {Cout}p

* === Load resistor ===
Rload vout 0 {Rload}

.options reltol=0.003 method=gear

* === Measurements ===
.control
* Transient — 50us for steady state with 2 stages
tran 1n 50u

* Measure output voltage in steady state (last 10us)
meas tran vout_avg avg v(vout) from=40u to=50u
echo "RESULT_VOUT_V" $&vout_avg

* Output ripple
meas tran vout_max max v(vout) from=40u to=50u
meas tran vout_min min v(vout) from=40u to=50u
let ripple = (vout_max - vout_min) * 1000
echo "RESULT_RIPPLE_MV" $&ripple

* Output current
let iout = vout_avg / {Rload}
let iout_ma = iout * 1000
echo "RESULT_IOUT_MA" $&iout_ma

* Input power
meas tran avg_idd avg i(Vdd) from=40u to=50u
let pin = abs(avg_idd) * 1.8
let pout = vout_avg * iout
let eff = pout / pin * 100
echo "RESULT_EFFICIENCY_PCT" $&eff

* Startup time (90% of final value)
let target90 = vout_avg * 0.9
meas tran startup_t when v(vout)=target90 rise=1
let startup_us = startup_t * 1e6
echo "RESULT_STARTUP_US" $&startup_us

echo "RESULT_DONE"
.endc

.end
