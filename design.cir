* SKY130 3-Stage Dickson Charge Pump
* 5V NMOS diodes (body=0 for proper junction bias), 3 flying caps
* Overcomes Vth body-effect with extra stages

.lib "sky130_models/sky130.lib.spice" tt

* Clock parameter
.param thalf_val = {Thalf}
.param tperiod_val = 2*thalf_val

* Supply
Vdd vdd 0 1.8
Vss vss 0 0

* Two-phase non-overlapping clocks
Vclk1 clk1 0 PULSE(0 1.8 0 0.1n 0.1n 'thalf_val*1e-9' 'tperiod_val*1e-9')
Vclk2 clk2 0 PULSE(0 1.8 'thalf_val*1e-9' 0.1n 0.1n 'thalf_val*1e-9' 'tperiod_val*1e-9')

* === Stage 0: Input diode VDD -> n1 ===
XD1 vdd vdd n1 0 sky130_fd_pr__nfet_g5v0d10v5 W={Wd}u L={Ld}u nf=5

* Stage 1 flying cap (clk1)
C1 n1 clk1 {Cfly}p

* === Stage 1: Transfer diode n1 -> n2 ===
XD2 n1 n1 n2 0 sky130_fd_pr__nfet_g5v0d10v5 W={Wd}u L={Ld}u nf=5

* Stage 2 flying cap (clk2)
C2 n2 clk2 {Cfly}p

* === Stage 2: Transfer diode n2 -> n3 ===
XD3 n2 n2 n3 0 sky130_fd_pr__nfet_g5v0d10v5 W={Wd}u L={Ld}u nf=5

* Stage 3 flying cap (clk1)
C3 n3 clk1 {Cfly}p

* === Stage 3: Output diode n3 -> vout ===
XD4 n3 n3 vout 0 sky130_fd_pr__nfet_g5v0d10v5 W={Wd}u L={Ld}u nf=5

* === Output filter cap ===
Cout vout 0 {Cout}p

* === Load ===
Rload vout 0 {Rload}

.options reltol=0.003 method=gear

* === Measurements ===
.control
* Transient — 30us for steady state
tran 2n 30u

* Measure output voltage in steady state (last 5us)
meas tran vout_avg avg v(vout) from=25u to=30u
echo "RESULT_VOUT_V" $&vout_avg

* Output ripple
meas tran vout_max max v(vout) from=25u to=30u
meas tran vout_min min v(vout) from=25u to=30u
let ripple = (vout_max - vout_min) * 1000
echo "RESULT_RIPPLE_MV" $&ripple

* Output current
let iout = vout_avg / {Rload}
let iout_ma = iout * 1000
echo "RESULT_IOUT_MA" $&iout_ma

* Input power
meas tran avg_idd avg i(Vdd) from=25u to=30u
let pin = abs(avg_idd) * 1.8
let pout = vout_avg * iout
let eff = pout / pin * 100
echo "RESULT_EFFICIENCY_PCT" $&eff

* Startup time (90% of final value)
let target90 = vout_avg * 0.9
meas tran startup_t when v(vout)=target90 rise=1
let startup_us = startup_t * 1e6
echo "RESULT_STARTUP_US" $&startup_us

echo "RESULT_DONE"
.endc

.end
