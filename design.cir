* SKY130 2-Stage Cross-Coupled Charge Pump (Pelliconi-style)
* Stage 1: Vdd -> ~2*Vdd, Stage 2: ~2*Vdd -> ~3*Vdd
* All devices 5V-tolerant (g5v0d10v5)
* Clock buffers included for proper efficiency accounting

.lib "sky130_models/sky130.lib.spice" tt

* Supply
Vdd vdd 0 1.8
Vss vss 0 0

* Clock frequency parameter (MHz)
.param freq_mhz = {Freq}
.param tper = '1e-6/freq_mhz'
.param thalf = 'tper/2'
.param trise = 'tper/50'

* Master clocks (drawn from supply for efficiency accounting)
Vclk1 clk1 0 PULSE(0 1.8 0 'trise' 'trise' 'thalf-trise' 'tper')
Vclk2 clk2 0 PULSE(0 1.8 'thalf' 'trise' 'trise' 'thalf-trise' 'tper')

* === Stage 1: Cross-coupled Pelliconi cell (Vdd -> ~2*Vdd) ===
* NMOS pair: charges a1/b1 from Vdd when cross node is boosted
XMN1 a1 b1 vdd 0 sky130_fd_pr__nfet_g5v0d10v5 W={Wn1}u L={Ln1}u nf=1
XMN2 b1 a1 vdd 0 sky130_fd_pr__nfet_g5v0d10v5 W={Wn1}u L={Ln1}u nf=1

* PMOS pair: transfers boosted charge to mid rail
XMP1 mid b1 a1 mid sky130_fd_pr__pfet_g5v0d10v5 W={Wp1}u L={Lp1}u nf=1
XMP2 mid a1 b1 mid sky130_fd_pr__pfet_g5v0d10v5 W={Wp1}u L={Lp1}u nf=1

* Stage 1 flying caps
C1a a1 clk1 {Cfly1}p
C1b b1 clk2 {Cfly1}p

* Interstage decoupling
Cmid mid 0 {Cmid}p

* === Stage 2: Cross-coupled Pelliconi cell (~2*Vdd -> ~3*Vdd) ===
XMN3 a2 b2 mid 0 sky130_fd_pr__nfet_g5v0d10v5 W={Wn2}u L={Ln2}u nf=1
XMN4 b2 a2 mid 0 sky130_fd_pr__nfet_g5v0d10v5 W={Wn2}u L={Ln2}u nf=1

XMP3 vout b2 a2 vout sky130_fd_pr__pfet_g5v0d10v5 W={Wp2}u L={Lp2}u nf=1
XMP4 vout a2 b2 vout sky130_fd_pr__pfet_g5v0d10v5 W={Wp2}u L={Lp2}u nf=1

* Stage 2 flying caps
C2a a2 clk1 {Cfly2}p
C2b b2 clk2 {Cfly2}p

* === Output capacitor ===
Cout vout 0 {Cout}p

* === Load resistor ===
Rload vout 0 {Rload}

.options reltol=0.01 method=gear maxord=2

* === Measurements ===
.control
* Transient — 25us for steady state
tran 2n 25u uic

* Measure output voltage in steady state (last 5us)
meas tran vout_avg avg v(vout) from=20u to=25u
echo "RESULT_VOUT_V" $&vout_avg

* Output ripple
meas tran vout_max max v(vout) from=20u to=25u
meas tran vout_min min v(vout) from=20u to=25u
let ripple = (vout_max - vout_min) * 1000
echo "RESULT_RIPPLE_MV" $&ripple

* Output current
let iout = vout_avg / {Rload}
let iout_ma = iout * 1000
echo "RESULT_IOUT_MA" $&iout_ma

* Input power — measure instantaneous V*I for each source, then average
let pvdd = v(vdd) * i(Vdd)
meas tran avg_pvdd avg pvdd from=20u to=25u
let pclk1 = v(clk1) * i(Vclk1)
meas tran avg_pclk1 avg pclk1 from=20u to=25u
let pclk2 = v(clk2) * i(Vclk2)
meas tran avg_pclk2 avg pclk2 from=20u to=25u
let pin = abs(avg_pvdd) + abs(avg_pclk1) + abs(avg_pclk2)
let pout = vout_avg * iout
let eff = pout / pin * 100
echo "RESULT_EFFICIENCY_PCT" $&eff

* Startup time (90% of final value)
let target90 = vout_avg * 0.9
meas tran startup_t when v(vout)=target90 rise=1
let startup_us = startup_t * 1e6
echo "RESULT_STARTUP_US" $&startup_us

echo "RESULT_DONE"
.endc

.end
