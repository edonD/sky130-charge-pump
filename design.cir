* SKY130 Cross-Coupled Voltage Doubler — Proper Topology
* Two-phase clock, all 5V-tolerant devices, cross-coupled NMOS+PMOS

.lib "sky130_models/sky130.lib.spice" tt

* Clock parameter
.param thalf_val = {Thalf}
.param tperiod_val = 2*thalf_val

* Supply
Vdd vdd 0 1.8
Vss vss 0 0

* Two-phase non-overlapping clocks
Vclk1 clk1 0 PULSE(0 1.8 0 0.1n 0.1n 'thalf_val*1e-9' 'tperiod_val*1e-9')
Vclk2 clk2 0 PULSE(0 1.8 'thalf_val*1e-9' 0.1n 0.1n 'thalf_val*1e-9' 'tperiod_val*1e-9')

* === Flying capacitors (pumped by clocks) ===
Cf1 na clk1 {Cfly}p
Cf2 nb clk2 {Cfly}p

* === Cross-coupled NMOS charge transfer (5V-tolerant — drain sees up to 2*VDD) ===
* MN1: when nb is high (boosted to 2*VDD), MN1 turns on, charges na to VDD
* MN2: when na is high (boosted to 2*VDD), MN2 turns on, charges nb to VDD
XMn1 na nb vdd vdd sky130_fd_pr__nfet_g5v0d10v5 W={Wn}u L={Ln}u nf=1
XMn2 nb na vdd vdd sky130_fd_pr__nfet_g5v0d10v5 W={Wn}u L={Ln}u nf=1

* === Cross-coupled PMOS output switches (5V-tolerant) ===
* MP1: source=na, gate=nb, drain=vout — ON when na is boosted, nb is low
* MP2: source=nb, gate=na, drain=vout — ON when nb is boosted, na is low
XMp1 vout nb na na sky130_fd_pr__pfet_g5v0d10v5 W={Wp}u L={Lp}u nf=1
XMp2 vout na nb nb sky130_fd_pr__pfet_g5v0d10v5 W={Wp}u L={Lp}u nf=1

* === Output filter cap ===
Cout vout vss {Cout}p

* === Load ===
Rload vout vss {Rload}

.options reltol=0.003 method=gear

* === Measurements ===
.control
* Transient — run long enough for steady state (50us)
tran 0.5n 50u

* Measure output voltage in steady state (last 5us)
meas tran vout_avg avg v(vout) from=45u to=50u
echo "RESULT_VOUT_V" $&vout_avg

* Output ripple
meas tran vout_max max v(vout) from=45u to=50u
meas tran vout_min min v(vout) from=45u to=50u
let ripple = (vout_max - vout_min) * 1000
echo "RESULT_RIPPLE_MV" $&ripple

* Output current
let iout = vout_avg / {Rload}
let iout_ma = iout * 1000
echo "RESULT_IOUT_MA" $&iout_ma

* Input power
meas tran avg_idd avg i(Vdd) from=45u to=50u
let pin = abs(avg_idd) * 1.8
let pout = vout_avg * iout
let eff = pout / pin * 100
echo "RESULT_EFFICIENCY_PCT" $&eff

* Startup time (90% of final value)
let target90 = vout_avg * 0.9
meas tran startup_t when v(vout)=target90 rise=1
let startup_us = startup_t * 1e6
echo "RESULT_STARTUP_US" $&startup_us

echo "RESULT_DONE"
.endc

.end
